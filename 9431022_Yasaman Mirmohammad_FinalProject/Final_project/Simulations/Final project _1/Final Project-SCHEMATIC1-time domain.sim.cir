** Profile: "SCHEMATIC1-time domain"  [ D:\A\e, sources\Electrical Circuit\Project\Final project _1\Final Project-SCHEMATIC1-time domain.sim ]

** Creating circuit file "Final Project-SCHEMATIC1-time domain.sim.cir"
** WARNING: THIS AUTOMATICALLY GENERATED FILE MAY BE OVERWRITTEN BY SUBSEQUENT SIMULATIONS

*Libraries:
* Local Libraries :
* From [PSPICE NETLIST] section of d:\orcad\PSpice\PSpice.ini file:
.lib "nom.lib"

*Analysis directives:
.TRAN  0 1000ns 0
.PROBE V(*) I(*) W(*) D(*) NOISE(*)
.INC "..\..\..\..\..\orcad\capture\library\pspice\Final Project-SCHEMATIC1.net"

.END
